ADE simulation setup
Test dff_r_dff_r_1: dff_r/dff_r/schematic, simulator spectre
  Models: /home/ee577@vlab.usc.edu/CDS_GPDK45/gpdk045_v_5_0/gpdk045/../models/spectre/gpdk045.scs[mc]
  Temperature: 27
  Files: vectors /home/danielni@vlab.usc.edu/work_gpdk045/ALU_vectors/t10_dff_r/t10_dff_r.vec
  Stimulus vdd: voltage dc dc=1 srcType=dc
  Stimulus gnd: voltage dc dc=0 srcType=dc
  Analysis tran: stop=110n
  Signals: /RST, /CLK, /D, /Q
Run mode: Single Run, Sweeps and Corners
