ADE simulation setup
Run mode: Single Run, Sweeps and Corners
Tests:
  dff_r_dff_r_1: dff_r/dff_r/schematic, simulator spectre
    Outputs: /RST; /CLK; /D; /Q
