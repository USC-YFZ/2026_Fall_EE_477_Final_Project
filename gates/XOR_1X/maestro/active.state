ADE simulation setup
Test gates_XOR_1X_1: gates/XOR_1X/schematic, simulator spectre
  Models: /home/ee577@vlab.usc.edu/CDS_GPDK45/gpdk045_v_5_0/gpdk045/../models/spectre/gpdk045.scs[mc]
  Temperature: 27
  Stimulus input1: voltage bit val1=1 val0=0 rise=10p fall=10p period=1n srcType=bit data=10011001
  Stimulus input2: voltage bit val1=1 val0=0 rise=10p fall=10p period=1n srcType=bit data=00111100
  Stimulus vdd: voltage dc dc=1 srcType=dc
  Stimulus gnd: voltage dc dc=0 srcType=dc
  Analysis tran: stop=10n
  Signals: /input1, /input2, /output, /vdd, /gnd
Run mode: Single Run, Sweeps and Corners
