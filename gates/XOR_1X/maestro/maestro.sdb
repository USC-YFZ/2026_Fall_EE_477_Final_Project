ADE simulation setup
Run mode: Single Run, Sweeps and Corners
Tests:
  gates_XOR_1X_1: gates/XOR_1X/schematic, simulator spectre
    Outputs: /input1; /input2; /output; /vdd; /gnd
