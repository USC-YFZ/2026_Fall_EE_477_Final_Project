ADE simulation setup
Run mode: Single Run, Sweeps and Corners
Tests:
  gates_1_bit_adder_1: gates/1_bit_adder/schematic, simulator spectre
    Outputs: /A; /B; /Cin; /S; /Cout
