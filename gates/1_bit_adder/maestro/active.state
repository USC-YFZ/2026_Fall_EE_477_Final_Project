ADE simulation setup
Test gates_1_bit_adder_1: gates/1_bit_adder/schematic, simulator spectre
  Models: /home/ee577@vlab.usc.edu/CDS_GPDK45/gpdk045_v_5_0/gpdk045/../models/spectre/gpdk045.scs[mc]
  Temperature: 27
  Stimulus A: voltage bit val1=1 val0=0 rise=10p fall=10p period=1n srcType=bit data=1100101010101
  Stimulus gnd: voltage dc dc=0 srcType=dc
  Stimulus Cin: voltage bit val1=1 val0=0 rise=10p fall=10p period=1n srcType=bit data=000011110101
  Stimulus B: voltage bit val1=1 val0=0 rise=10p fall=10p period=1n srcType=bit data=010101101001
  Stimulus vdd: voltage dc dc=1 srcType=dc
  Analysis tran: stop=10n
  Signals: /A, /B, /Cin, /S, /Cout
Run mode: Single Run, Sweeps and Corners
