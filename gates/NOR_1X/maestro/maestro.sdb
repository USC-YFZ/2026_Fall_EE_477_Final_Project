ADE simulation setup
Run mode: Single Run, Sweeps and Corners
Tests:
  gates_NOR_1X_1: gates/NOR_1X/schematic, simulator spectre
    Outputs: /input1; /input2; /output
