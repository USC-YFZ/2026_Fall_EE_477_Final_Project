ADE simulation setup
Run mode: Single Run, Sweeps and Corners
Tests:
  gates_INV_1X_1: gates/INV_1X/schematic, simulator spectre
    Outputs: /input; /output
