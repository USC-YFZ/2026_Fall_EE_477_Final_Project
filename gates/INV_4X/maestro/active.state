ADE simulation setup
Test gates_INV_1X_1: gates/INV_1X/schematic, simulator spectre
  Models: /home/ee577@vlab.usc.edu/CDS_GPDK45/gpdk045_v_5_0/gpdk045/../models/spectre/gpdk045.scs[mc]
  Temperature: 27
  Stimulus vdd: voltage dc dc=1 srcType=dc
  Stimulus gnd: voltage dc dc=0 srcType=dc
  Stimulus input: voltage bit val1=1 val0=0 rise=10p fall=10p period=1n srcType=bit data=1001
  Analysis tran: stop=10n
  Signals: /input, /output
Run mode: Single Run, Sweeps and Corners
