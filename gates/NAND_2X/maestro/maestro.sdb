ADE simulation setup
Run mode: Single Run, Sweeps and Corners
Tests:
  gates_NAND_1X_1: gates/NAND_1X/schematic, simulator spectre
    Outputs: /input1; /input2; /output
